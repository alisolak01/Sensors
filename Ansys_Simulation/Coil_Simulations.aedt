# Ansys Electronics Desktop project, version 2023.2
materials:
  vacuum: permittivity=1
  copper: permeability=0.999991 conductivity=58000000
  air: permittivity=1.0006 permeability=1.0000004
  aluminum: permeability=1.000021 conductivity=38000000

design HFSSDesign1 (HFSS, HFSS Terminal Network, model units mm)
options: Allow_Material_Override
variables:
  xpos = 40
geometry:
  BOTTOM_LAYER_1, BOTTOM_LAYER_3, TOP_LAYER_4 [copper] = imported_body(C:/temp/0B2A392601699370029138..x_t)
  Cylinder1 [copper] = cylinder(axis=Z, base_centre=(36.08999894mm, 60.21999894mm, -0.73mm), radius=0.09219533mm, height=1.53mm)
  Box1 [copper] = box(corner=(26.78204394mm, 49.78550622mm, 0.8mm), size=(-5.78204394mm, 0.2025mm, -0.035mm))
  Box2 [copper] = box(corner=(25.7999992mm, 60.11999914mm, -0.73mm), size=(-4.8mm, 0.2000005mm, -0.035mm))
  Box3 [aluminum] = box(corner=(40mm, 45mm, 2mm), size=(15mm, 35mm, 1mm))
boundaries and excitations:
  BOTTOM_LAYER_1_T1: Terminal port=1 Edges=BOTTOM_LAYER_1.edge(at (25.8, 60.22, -0.73)) TerminalResistance=50ohm
  1: Lumped Port Faces=Box2.face(+z) LumpedPortType=Terminal Impedance=50ohm
  2: Lumped Port Faces=Box1.face(+z) LumpedPortType=Terminal Impedance=50ohm
  reference conductors: Box1
mesh:
  Length1: LengthBased Faces=BOTTOM_LAYER_1.face(all 6) BOTTOM_LAYER_3.face(all 3) TOP_LAYER_4.face(all 121) Cylinder1.face(all 3) Box1.face(all 6) Box2.face(all 6) Box3.face(all 6) NumMaxElem=1000 MaxLength=354.43932mm
  initial mesh: GlobalSurfApproximation{CurvedSurfaceApproxChoice=UseSlider SliderMeshSettings=1} MeshMethod=AnsoftClassic
setups:
  Setup1: HfssDriven Frequency=10MHz MaxDeltaS=0.02 MaximumPasses=6 MinimumPasses=1 MinimumConvergedPasses=1 PercentRefinement=30 BasisOrder=1 PortAccuracy=2 DrivenSolverType="Iterative Solver" IterativeResidual=1e-06 DDMSolverResidual=0.0001 VariableFlagsForDerivatives(1)
    sweep Frequency_sweep: 100kHz to 100MHz, log, 30 per decade; Type=Discrete SaveFields
source amplitudes:
  1:1: 1V 0deg
field plots:
  Vector_H1: H Field over TOP_LAYER_4.face(all 121) on Setup1 : LastAdaptive at Freq=0.01GHz Phase=0deg
  Vector_E1: E Field over TOP_LAYER_4.face(all 121) on Setup1 : LastAdaptive at Freq=0.01GHz Phase=0deg

design Maxwell_NEW_COIL_FINAL (Maxwell 3D, EddyCurrent, model units mm)
options: Allow_Material_Override
variables:
  xval = 0
  xpos = 40
geometry:
  Box3 [aluminum] = box(corner=(32.731mm, 49.4mm, 2.8mm), size=(15mm, 30mm, 1.18mm))
  BOTTOM_LAYER_1, BOTTOM_LAYER_2, BOTTOM_LAYER_3, BOTTOM_LAYER_5, TOP_LAYER_6..TOP_LAYER_10, TOP_LAYER_12 [copper] = imported_body(C:/temp/58337541617029081633..x_t)
  Cylinder1 [copper] = cylinder(axis=Z, base_centre=(170.9219975mm, 64.4959975mm, 0.765mm), radius=0.127mm, height=-1.53mm)
  Box4 [copper] = box(corner=(184.2262mm, 64.9986mm, 0.8mm), size=(0.0508mm, 0.254mm, -0.035mm))
  Region [air] = region(percentage_offset: +X=0, -X=100, +Y=100, -Y=100, +Z=500, -Z=500)
boundaries and excitations:
  Current1: Current Faces=Box4.face(+x) Phase=0deg Current=1mA IsSolid=true Point_out_of_terminal=false
  Current2: Current Faces=BOTTOM_LAYER_1.face(at (184.277, 62.484, -0.7475)) Phase=0deg Current=1mA IsSolid=true Point_out_of_terminal=true
parameters:
  Matrix1: Matrix Current1:
mesh:
  initial mesh: GlobalSurfApproximation{CurvedSurfaceApproxChoice=UseSlider SliderMeshSettings=1} MeshMethod=AnsoftClassic
setups:
  Setup1: EddyCurrent MaximumPasses=2 MinimumPasses=2 MinimumConvergedPasses=1 PercentRefinement=30 PercentError=10 RelativeResidual=1e-05 NonLinearResidual=0.0001 Frequency=800kHz SweepRanges{point 800kHz} SaveAllFields
field plots:
  Vector_H1: H in TOP_LAYER_12 on Setup1 : LastAdaptive at Freq=800kHz Phase=0deg
  Vector_Jsurf1: Jsurf over Box3 on Setup1 : LastAdaptive at Freq=800kHz Phase=0deg
reports:
  L Plot 1: Matrix1.L(Current1,Current1) vs xpos on Setup1 : LastAdaptive [Freq=all]
  Z Plot 1: re(Matrix1.Z(Current1,Current1)) vs xpos on Setup1 : LastAdaptive [Freq=all]
  Lnom Plot 1: Matrix1.Lnom(Current1,Current1) vs xpos on Setup1 : LastAdaptive [Freq=all]
  Z Plot 2: im(Matrix1.Z(Current1,Current1)) vs xpos on Setup1 : LastAdaptive [Freq=all]
  R Plot 1: Matrix1.R(Current1,Current1) vs xpos on Setup1 : LastAdaptive [Freq=all]

design Maxwell3DDesign2 (Maxwell 3D, EddyCurrent, model units mm)
options: Allow_Material_Override
geometry:
  gbl_1, gtl_2 [copper] = imported_body(C:/temp/28D925840169990417723..x_t)
  Box1 [copper] = box(corner=(13.800025mm, 15.100025mm, -0.73mm), size=(-0.200025mm, -0.200025mm, 1.495mm))
  Box2 [copper] = box(corner=(2.4mm, 15.100025mm, 0.765mm), size=(-2.4mm, -0.200025mm, 0.035mm))
  Box3 [copper] = box(corner=(2.4mm, 15.100025mm, -0.73mm), size=(-2.4mm, -0.2mm, -0.035mm))
  Region [vacuum] = region(percentage_offset: +X=100, -X=0, +Y=100, -Y=100, +Z=100, -Z=100)
boundaries and excitations:
  Current1: Current Faces=Box2.face(-x) Phase=0deg Current=1mA IsSolid=true Point_out_of_terminal=false
  Current2: Current Faces=Box3.face(-x) Phase=0deg Current=1mA IsSolid=true Point_out_of_terminal=true
parameters:
  Matrix1: Matrix Current1:
mesh:
  initial mesh: GlobalSurfApproximation{CurvedSurfaceApproxChoice=UseSlider SliderMeshSettings=2} GlobalCurvilinear{Apply}
setups:
  Setup1: EddyCurrent MaximumPasses=2 MinimumPasses=2 MinimumConvergedPasses=1 PercentRefinement=30 PercentError=10 NonLinearResidual=0.0001 Frequency=60Hz SweepRanges{10kHz to 1MHz step 10kHz} SaveAllFields
reports:
  Z Plot 1: re(Matrix1.Z(Current1,Current1)) vs Freq on Setup1 : LastAdaptive
  L Plot 1: Matrix1.L(Current1,Current1) vs Freq on Setup1 : LastAdaptive
  R Plot 1: Matrix1.R(Current1,Current1) vs Freq on Setup1 : LastAdaptive

design Q3DDesign1 (Q3D Extractor, model units mm)
options: Background_Material=air SParamCalcMethod=EqTransLine Allow_Material_Override Calculate_Lossy_Dielectrics
variables:
  xpos = 0mm
geometry:
  BOTTOM_LAYER_1, BOTTOM_LAYER_3, TOP_LAYER_4 [copper] = imported_body(C:/temp/3DFF60484169929373943..x_t)
  Cylinder1 [copper] = cylinder(axis=Z, base_centre=(36.08999894mm, 60.21999894mm, -0.73mm), radius=0.098489977mm, height=1.53mm)
  Metal_target [aluminum] = box(corner=(xpos, 48mm, 2.5mm), size=(-14mm, 30mm, -0.5mm))
boundaries and excitations:
  BOTTOM_LAYER_1: SignalNet Objects=[BOTTOM_LAYER_1, BOTTOM_LAYER_3, TOP_LAYER_4, Cylinder1]
  Box2: SignalNet Objects=Metal_target
  Source1: Source Faces=TOP_LAYER_4.face(at (25.7848, 49.8868, 0.7825)) TerminalType=ConstantVoltage Net=BOTTOM_LAYER_1
  Sink1: Sink Faces=BOTTOM_LAYER_1.face(at (25.8, 60.22, -0.7475)) TerminalType=ConstantVoltage Net=BOTTOM_LAYER_1
mesh:
  initial mesh: GlobalSurfApproximation{CurvedSurfaceApproxChoice=UseSlider SliderMeshSettings=1} MeshMethod=AnsoftClassic
setups:
  Setup1: Matrix AdaptiveFreq=10MHz SaveFields Cap{MaxPass=10 MinPass=1 MinConvPass=1 PerError=1 PerRefine=30 AutoIncreaseSolutionOrder SolutionOrder=High Solver_Type=Iterative} DC{Cond{MaxPass=10 MinPass=1 MinConvPass=1 PerError=1 PerRefine=30} Mult{MaxPass=1 MinPass=1 MinConvPass=1 PerError=1 PerRefine=30} Solution_Order=Normal} AC{MaxPass=10 MinPass=1 MinConvPass=1 PerError=1 PerRefine=30} ErrorValue=0.1
    sweep Sweep1: 1kHz to 10000kHz, log, 30 per decade; Type=Interpolating InterpTolerance=0.5 InterpMaxSolns=50
source amplitudes:
  BOTTOM_LAYER_1:Source1: AC 1A
  BOTTOM_LAYER_1: Cap 1V 0deg
  Box2: Cap 0V 0deg
  BOTTOM_LAYER_1:Source1: DC 1A
optimetrics:
  ParametricSetup1: Parametric Sim._Setups=[Setup1]
    sweep xpos: LIN 200mm 0mm -5mm
field plots:
  Mag_SurfaceJac1: JAC over TOP_LAYER_4.face(all 121) on Setup1 : LastAdaptive at Freq=10MHz
  Vector_H1: Vector_H over TOP_LAYER_4.face(all 121) on Setup1 : LastAdaptive at Freq=10MHz
reports:
  ACL Matrix Plot 1: ACL(BOTTOM_LAYER_1:Source1,BOTTOM_LAYER_1:Source1) vs Freq on Setup1 : Sweep1
  C Matrix Plot 1: C(BOTTOM_LAYER_1,BOTTOM_LAYER_1) vs Freq on Setup1 : Sweep1
  ACR Matrix Plot 1: ACR(BOTTOM_LAYER_1:Source1,BOTTOM_LAYER_1:Source1) vs xpos on Setup1 : Sweep1 [Freq=1e-06GHz]
  ACR Matrix Plot 2: ACR(BOTTOM_LAYER_1:Source1,BOTTOM_LAYER_1:Source1) vs Freq on Setup1 : Sweep1 [xpos=0mm]
  C Matrix Plot 2: C(Box2,BOTTOM_LAYER_1) vs xpos on Setup1 : Sweep1 [Freq=1e-06GHz]
  ACL Matrix Plot 2: ACL(BOTTOM_LAYER_1:Source1,BOTTOM_LAYER_1:Source1) vs xpos on Setup1 : Sweep1 [Freq=1e-06GHz]

design Q3DDesign2 (Q3D Extractor, model units mm)
options: Background_Material=air SParamCalcMethod=EqTransLine Allow_Material_Override Calculate_Lossy_Dielectrics
geometry:
  BOTTOM_LAYER_1, BOTTOM_LAYER_7, TOP_LAYER_8, TOP_LAYER_11 [copper] = imported_body(C:/temp/657D60484169929683576..x_t)
  Cylinder2 [copper] = cylinder(axis=Z, base_centre=(29.5099994mm, 59.6400001mm, -0.73mm), radius=0.127mm, height=1.495mm)
  Cylinder3 [copper] = cylinder(axis=Z, base_centre=(184.42024mm, 65.20158791mm, -0.73mm), radius=0.10047151mm, height=1.495mm)
boundaries and excitations:
  TOP_IND: SignalNet Objects=[BOTTOM_LAYER_1, TOP_LAYER_11, Cylinder2]
  BOT_IND: SignalNet Objects=[BOTTOM_LAYER_7, TOP_LAYER_8, Cylinder3]
  Source1: Source Faces=TOP_LAYER_11.face(at (19.1926, 49.3728, 0.7825)) TerminalType=ConstantVoltage Net=TOP_IND
  Sink1: Sink Faces=BOTTOM_LAYER_1.face(at (19.25, 59.64, -0.7475)) TerminalType=ConstantVoltage Net=TOP_IND
mesh:
  initial mesh: GlobalSurfApproximation{CurvedSurfaceApproxChoice=UseSlider SliderMeshSettings=1} MeshMethod=AnsoftClassic
setups:
  Setup1: Matrix AdaptiveFreq=10MHz SaveFields Cap{MaxPass=10 MinPass=1 MinConvPass=1 PerError=1 PerRefine=30 AutoIncreaseSolutionOrder SolutionOrder=High Solver_Type=Iterative} DC{Cond{MaxPass=10 MinPass=1 MinConvPass=1 PerError=1 PerRefine=30} Mult{MaxPass=1 MinPass=1 MinConvPass=1 PerError=1 PerRefine=30} Solution_Order=Normal} AC{MaxPass=10 MinPass=1 MinConvPass=1 PerError=1 PerRefine=30} ErrorValue=0.1
    sweep Sweep1: 10kHz to 10000kHz, log, 30 per decade; Type=Discrete
source amplitudes:
  TOP_IND:Source1: AC 1A
  BOT_IND: Cap 0V 0deg
  TOP_IND: Cap 1V 0deg
  TOP_IND:Source1: DC 1A
reports:
  ACL Matrix Plot 1: ACL(TOP_IND:Source1,TOP_IND:Source1) vs Freq on Setup1 : Sweep1
  C Matrix Plot 1: C(TOP_IND,TOP_IND) vs Freq on Setup1 : Sweep1
  ACR Matrix Plot 1: ACR(TOP_IND:Source1,TOP_IND:Source1) vs Freq on Setup1 : Sweep1

design Q3D_NEW_COIL_FINAL (Q3D Extractor, model units mm)
options: SParamCalcMethod=EqTransLine Allow_Material_Override Calculate_Lossy_Dielectrics
geometry:
  BOTTOM_LAYER_1, BOTTOM_LAYER_2, BOTTOM_LAYER_3, BOTTOM_LAYER_5, TOP_LAYER_6..TOP_LAYER_10, TOP_LAYER_12 [copper] = imported_body(C:/temp/58337541617029081633..x_t)
  Cylinder1 [copper] = cylinder(axis=Z, base_centre=(170.9219975mm, 64.4959975mm, 0.765mm), radius=0.127mm, height=-1.53mm)
boundaries and excitations:
  BOTTOM_LAYER_1: SignalNet Objects=[BOTTOM_LAYER_1, BOTTOM_LAYER_2, BOTTOM_LAYER_3, BOTTOM_LAYER_5, TOP_LAYER_6..TOP_LAYER_10, TOP_LAYER_12, Cylinder1]
  Source1: Source Faces=TOP_LAYER_9.face(at (184.226, 65.1256, 0.7825)) TerminalType=UniformCurrent Net=BOTTOM_LAYER_1
  Sink1: Sink Faces=BOTTOM_LAYER_1.face(at (184.277, 62.484, -0.7475)) TerminalType=UniformCurrent Net=BOTTOM_LAYER_1
mesh:
  initial mesh: GlobalSurfApproximation{CurvedSurfaceApproxChoice=UseSlider SliderMeshSettings=1} MeshMethod=AnsoftClassic
setups:
  Setup1: Matrix AdaptiveFreq=800kHz Cap{MaxPass=2 MinPass=1 MinConvPass=1 PerError=10 PerRefine=30 AutoIncreaseSolutionOrder SolutionOrder=Normal Solver_Type=Iterative} DC{SolveResOnly Cond{MaxPass=2 MinPass=1 MinConvPass=1 PerError=10 PerRefine=30} Mult{MaxPass=2 MinPass=1 MinConvPass=1 PerError=10 PerRefine=30} Solution_Order=Normal} AC{MaxPass=2 MinPass=1 MinConvPass=1 PerError=10 PerRefine=30} ErrorValue=0.1
    sweep Sweep1: 1kHz to 20MHz step 10kHz; Type=Discrete
source amplitudes:
  BOTTOM_LAYER_1:Source1: AC 1A
  BOTTOM_LAYER_1: Cap 1V 0deg
  BOTTOM_LAYER_1:Source1: DC 1A
reports:
  ACL Matrix Plot 1: ACL(BOTTOM_LAYER_1:Source1,BOTTOM_LAYER_1:Source1) vs Freq on Setup1 : Sweep1
  C Matrix Plot 1: C(BOTTOM_LAYER_1,BOTTOM_LAYER_1) vs Freq on Setup1 : Sweep1
  ACR Matrix Plot 1: ACR(BOTTOM_LAYER_1:Source1,BOTTOM_LAYER_1:Source1) vs Freq on Setup1 : Sweep1
